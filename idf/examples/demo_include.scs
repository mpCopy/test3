// demo_include.scs
simulator lang=spectre
library dl_demo_lib

section npn
include "./models/npnpwa1.scs"
include "./models/npnpwa2.scs"
endsection npn

section dio
include "./models/diodem2.scs"
endsection dio

endlibrary dl_demo_lib
