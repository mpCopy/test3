// Design: examples/power_amp
simulator lang=spectre
global 0
parameters Rout=12 Rcc=10 Remitin=200 Remitout=163
include "../../models/npnpwa1.scs"
include "../../models/npnpwa2.scs"

// examples/power_amp/schematic
Q0 (net44 Vin net15 0) npnpwa1
Q1 (net44 net15 net12 0) npnpwa2
Q2 (net44 net15 net9 0) npnpwa2
Q3 (net44 net15 net6 0) npnpwa2
Q4 (net15 Vcc2 net31 0) npnpwa2
Q5 (net12 Vcc2 net13 0) npnpwa2
Q6 (net9 Vcc2 net35 0) npnpwa2
Q7 (net6 Vcc2 net37 0) npnpwa2
R0 (Vcc1 net44) resistor r=10
R1 (net12 Vout) resistor r=Rout
R2 (net9 Vout) resistor r=Rout
R3 (net6 Vout) resistor r=Rout
R4 (net37 GND) resistor r=Remitout
R5 (net35 GND) resistor r=Remitout
R6 (net13 GND) resistor r=Remitout
R7 (net31 GND) resistor r=200
simulatorOptions options temp=27
