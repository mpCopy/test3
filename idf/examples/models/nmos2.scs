simulator lang=spectre

model nmos2 bsim3v3 type=n vtho=780.21E-03 vfb=-1 k1=943.84 k2=11.309e-03
+ k3=-6 k3b=1.8 w0=177.165E-09 nlx=850.49E-15 vbm=-3 dvt0=12.25
+ dvt1=578.81e-03 dvt2=-55.947 dvt0w=425.7e-03 dvt1w=5.0994e+06 dvt2w=-50
+ a0=1.335 b0=-129.11E-09 b1=2.3733E-06 a1=19.001e-03 a2=230.58e-03
+ ags=160E-03 keta=15 nsub=60e+15 nch=1e+18 ngate=100e+18 xj=150E-09
+ lint=50E-09 wint=97E-09 lln=1 lw=2.86664e-21 lwn=-29.9554e-03 wl=-100E-15
+ wln=-500e-03 ww=-100e-21 wwn=1 dwg=-6.8702E-09 tox=12.932E-09
+ toxm=12.932E-09 xt=155E-09 rdsw=471.06 prwb=62.398 prwg=8.2883 wr=1
+ binunit=1 mobmod=1 u0=483.57 vsat=130.16E03 ua=2.6362E-12 ub=2.7078E-18
+ uc=94.73E-12 drout=1 pclm=14.735 pdiblc1=18.267e-03 pdiblc2=2.2988e-03
+ pdiblcb=-223.38 pscbe1=631.49E06 pscbe2=32.435E-06 pvag=653.37e-03
+ delta=1E-03 cdsc=260.909E-06 cdscb=-148.316E-06 cdscd=914.72E-06
+ nfactor=435.175e-03 voff=-136.659E-03 dsub=1.3519 eta0=656.64e-03
+ etab=-223.02 alpha0=1.5126E-06 alpha1=1.52 beta0=27.4 rsh=64 sc=-1
+ hdif=380E-09 minr=100E-03 js=190.83E-09 jsw=75.937e-21 jssw=75.937e-21
+ n=1.0014 nj=1.0014 dskip=yes imelt=5E-03 ijth=5E-03 jmelt=100E06 vnds=-1
+ nds=1 cgso=16.63E-12 cgdo=16.63E-12 cgbo=17.06E-12 cgsl=395.15E-12
+ cgdl=395.15E-12 ckappa=4.8944 cj=950E-06 mj=297e-03 pb=691E-03 fc=500e-03
+ cjsw=152E-12 mjsw=65e-03 pbsw=530E-03 cjswg=329.02E-12 mjswg=629e-03
+ pbswg=1.283 fcsw=500e-03 capmod=2 dwc=173.35E-09 dlc=121.74E-09 clc=100E-09
+ cle=600e-03 elm=5 vfbcv=-1 acde=1.2 moin=15 noff=3.571 lwc=2.86664e-21
+ wlc=-100E-15 wwc=-100e-21 wmlt=1 lmlt=1 w=5E-06 l=5E-06 version=3.3 level=11
+ acm=13 tnom=25 eg=1.12452 gap1=702E-06 gap2=1.108E03 diomod=1
+ kt1=-416.28E-03 kt1l=763.84E-09 kt2=-48e-03 at=65.087E03 ua1=4E-09
+ ub1=-5.8E-18 uc1=-37.109E-12 prt=100 ute=-1.3 xti=2 tpb=1.673E-03
+ tpbsw=865.516E-06 tpbswg=1.7885E-03 tcj=829.011E-06 tcjsw=3.92986
+ tcjswg=881.806E-06 noimod=2 af=1 ef=1.0508 noia=108e+15 noib=1.20406e+06
+ noic=766e-15 noid=200e+12 em=290E06 gamma=666.667e-03 aigbinv=11.1
+ bigbinv=949E-06 cigbinv=6 eigbinv=1.1 nigbinv=3 aigbacc=13.6 bigbacc=1.71
+ cigbacc=75 nigbacc=1 aigsd=13.6 bigsd=1.71 cigsd=75 aigc=13.6 bigc=1.71
+ cigc=75 nigc=1 pigcd=1 dlcig=50E-09 ntox=1 toxref=3E-09 poxedge=1 wmax=1
+ wmin=230E-09 lmax=1 lmin=360E-09 alarm=none imax=5E-03 jmax=100E06
+ vbox=38.796 warn=on mos_method=a sa0=1E-06 saref=1E-06 sb0=1E-06 sbref=1E-06
+ scref=1E-06 njts=60 njtssw=60 njtsswg=60 mnr=21 xtss=20e-03 xtsd=20e-03
+ xtssws=20e-03 xtsswd=20e-03 xtsswgs=20e-03 xtsswgd=20e-03 xjbv=1
+ ijthrev=100e-03 nrfwd=1 msgskip=off
