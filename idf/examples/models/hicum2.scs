simulator lang=spectre
// sample spectre bht (HICUM) model

model npn2 bht version=2.1 tnom=25 type=npn
+ c10=0.376e-31 qp0=0.278e-13 ich=0.209e-1
+ hfc=0.1e1 hfe=1.e0 hjci=0.1e1 tr=1.e-9
+ cjei0=0.811e-14 vdei=0.95 zei=0.5 aljei=0.18e1
+ cjci0=0.116e-14 vdci=0.8e0 zci=0.333 vptci=0.416e3
+ rci0=0.1278e3 vlim=0.7 vpt=0.5e1 vces=0.1
+ t0=0.475e-11 dt0h=0.21e-11 tbvl=0.4e-11
+ tef0=0.18e-11 gtfe=0.14e1 thcs=0.3e-10
+ alhc=0.75 fthc=0.6 latb=0.3765e1 latl=0.342 fqi=0.9055
+ alit=0.45 alqf=0.225 favl=0.1186e1 qavl=0.111e-13 alfav=0.825e-4
+ alqav=0.196e-3 ibeis=0.116e-19 mbei=0.1015e1 ibeps=0.1e-29
+ mbep=0.2e1 ireis=0.116e-15 mrei=0.2e1 ireps=0.1e-29
+ mrep=0.2e1 fgeo=0.73e0 vdep=0.105e1 zep=0.4e0
+ aljep=0.24e1 vdcx=0.7 zcx=0.333 vptcx=0.1e3
+ fbc=0.1526 ibcxs=0.1e-29 mbcx=0.2e1 ibcis=0.116e-19
+ mbci=0.1015e1 vds=0.6 zs=0.447 vpts=0.1e4
+ vgb=0.117e1 alb=0.63e-2 zetaci=0.16e1 alvs=0.1e-2 alces=0.4e-3
+ zetarbi=0.588 zetarcx=0.223 zetarbx=0.206 msf=1.004
