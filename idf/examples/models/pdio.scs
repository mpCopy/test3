simulator lang=spectre

model pdio diode is=4e-6 isw=5e-11 ibv=.001 ik=2e6
+ n=1.1 rs=4 rsw=20 mj=0.4 cj=1e-3 cjsw=1e-9 vjsw=0.96
+ fc=0.4 pb=0.97 tgs=2
