simulator lang=spectre

// translated from npnpwa1.ads except leaving out
// Vtf, Approxqb, Ab, and Ffe.

model npnpwa1 bjt type=npn bf=130 ikf=0.01085 \
  ise=7.56E-13 ne=2 vaf=25 nf=1.03 tf=8.91e-12 \
  xtf=3.35 itf=0.0217 ptf=18 xtb=2.2 \
  br=5.123 ikr=0.056 isc=2.01e-12 \
  nc=2 var=0 nr=1 tr=1.6e-9 eg=1.11 is=2.15e-16 \
  imax=1 xti=8 tnom=25 nkf=0.5 iss=3.28e-13 ns=1 \
  cjc=1.045e-13 vjc=0.75 mjc=0.5 xcjc=0.2292 \
  fc=0.5 cje=1.935E-13 vje=0.85 mje=0.4 \
  cjs=1.092e-13 vjs=0.7 mjs=0.5 rb=317 irb=0 \
  rbm=10.63 re=1.79 rc=37.6 af=1 \
  bnoisefc=1 struct=vertical
